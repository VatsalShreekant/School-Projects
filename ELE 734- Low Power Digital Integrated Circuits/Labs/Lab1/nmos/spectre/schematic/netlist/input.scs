// Design: Lab1/nmos
simulator lang=spectre
global 0
include "/CMC/tools/cadence/IC5141USR6_lnx86/tools/dfII/samples/artist/ahdlLib/quantity.spectre"
parameters v2=1 v1=1.8
include "$CMOSP18_DIR/models/spectre/rf018.scs" section=tt
include "/home/student1/gcascian/ELE734/saveop.scs"

// Lab1/nmos/schematic
V0 (net5 0) vsource dc=v1 type=dc
V2 (net8 0) vsource dc=0 type=dc
V1 (net3 0) vsource dc= v2 type=dc
mosfet (net5 net3 0 net8) nch w=1u l=180.00n m=1 region=triode
simulatorOptions options temp=27
dcOp dc
dc dc dev=V2 param=dc start=-1.8 stop=1.8 step=.1
save mosfetd
