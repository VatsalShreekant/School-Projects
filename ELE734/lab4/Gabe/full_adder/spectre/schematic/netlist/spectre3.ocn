simulator( 'spectre )
design(	 "/home/student1/gcascian/ELE734/full_adder/spectre/schematic/netlist/netlist")
resultsDir( "/home/student1/gcascian/ELE734/full_adder/spectre/schematic" )
modelFile(
    '("$CMOSP18_DIR/models/spectre/rf018.scs" "tt")
    '("/home/student1/gcascian/ELE734/saveop.scs" "")
)
analysis('tran ?stop "200n"  )
temp( 27 )
run()
selectResult( 'tran )
plot(getData("/S") getData("/Co") getData("/net2") getData("/net6") getData("/net4") )
modelFile(
    '("$CMOSP18_DIR/models/spectre/rf018.scs" "tt")
    '("/home/student1/gcascian/ELE734/saveop.scs" "")
)
run()
selectResult( 'tran )
plot(getData("/S") getData("/Co") getData("/net2") getData("/net6") getData("/net4") )
