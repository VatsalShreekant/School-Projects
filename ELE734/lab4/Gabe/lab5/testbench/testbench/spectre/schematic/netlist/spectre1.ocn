simulator( 'spectre )
design(	 "/home/student1/a29yang/Desktop/ele734/lab4/testbench/testbench/spectre/schematic/netlist/netlist")
resultsDir( "/home/student1/a29yang/Desktop/ele734/lab4/testbench/testbench/spectre/schematic" )
modelFile(
    '("$CMOSP18_DIR/models/spectre/rf018.scs" "tt")
    '("/home/student1/a29yang/Desktop/ele734/lab1_v1/saveop.scs" "")
)
temp( 27 )
run()
