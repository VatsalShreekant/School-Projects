simulator( 'spectre )
design(	 "/home/student1/gcascian/ELE734/Lab1/nmos/spectre/schematic/netlist/netlist")
resultsDir( "/home/student1/gcascian/ELE734/Lab1/nmos/spectre/schematic" )
modelFile(
    '("$CMOSP18_DIR/models/spectre/rf018.scs" "tt")
    '("/home/student1/gcascian/ELE734/saveop.scs" "")
)
analysis('dc ?saveOppoint t  ?param "v1"  ?start "0"
		?stop "1.8"  ?step ".1"  )
desVar(	  "v1" 1.8	)
desVar(	  "v2" 1	)
save( 'i "/mosfet/D" )
temp( 27 )
run()
selectResult( 'dc )
plot(getData("/mosfet/D") )
modelFile(
    '("$CMOSP18_DIR/models/spectre/rf018.scs" "tt")
    '("/home/student1/gcascian/ELE734/saveop.scs" "")
)
analysis('dc ?dev "/V0"  ?param "dc"  )
run()
selectResult( 'dc )
plot(getData("/mosfet/D") )
modelFile(
    '("$CMOSP18_DIR/models/spectre/rf018.scs" "tt")
    '("/home/student1/gcascian/ELE734/saveop.scs" "")
)
analysis('dc ?dev "/V1"  )
run()
selectResult( 'dc )
plot(getData("/mosfet/D") )
modelFile(
    '("$CMOSP18_DIR/models/spectre/rf018.scs" "tt")
    '("/home/student1/gcascian/ELE734/saveop.scs" "")
)
run()
selectResult( 'dc )
plot(getData("/mosfet/D") )
modelFile(
    '("$CMOSP18_DIR/models/spectre/rf018.scs" "tt")
    '("/home/student1/gcascian/ELE734/saveop.scs" "")
)
analysis('dc ?dev "/V2"  ?start "-1.8"  )
run()
selectResult( 'dc )
plot(getData("/mosfet/D") )
